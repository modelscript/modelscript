* 2.45 GHz RF Front-End System Cascade Reference Deck
Vrf rf_in 0 DC 0 AC 1
Rsrc rf_in n1 50
Rstage1 n1 n2 50
Rload n2 0 50
.AC LIN 15 1.8G 3.2G
.END
