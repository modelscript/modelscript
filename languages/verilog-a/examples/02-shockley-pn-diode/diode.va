`include "disciplines.vams"
`include "constants.vams"

module pn_diode(a, c);
  inout a, c;
  electrical a, c;

  parameter real Is = 1.0e-14 from (0:inf);
  parameter real N = 1.05 from (0:inf);
  parameter real Rs = 1.5 from [0:inf);
  parameter real Cj0 = 2.0e-12 from [0:inf);
  parameter real Tt = 1.0e-9 from [0:inf);

  real Vd, Id, Qd;

  analog begin
    Vd = V(a, c);
    Id = Is * (limexp(Vd / (N * $vt)) - 1.0);
    Qd = Cj0 * Vd + Tt * Id;
    I(a, c) <+ Id + ddt(Qd);
  end
endmodule
