* Memristor Pinched Hysteresis Loop Testbench
Vin in 0 SIN(0 1.2 1.0)
Rseries in mem_p 50
Rmem_eq mem_p 0 1000
.TRAN 1m 2.0
.END
